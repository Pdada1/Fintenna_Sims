# Ansys Electronics Desktop project, version 2026.1
materials:
  vacuum: permittivity=1
  aluminum: permeability=1.000021 conductivity=38000000
  Rogers TMM 4 (tm): permittivity=4.5 dielectric_loss_tangent=0.002
  copper: permeability=0.999991 conductivity=58000000
  polyethylene: permittivity=2.25 dielectric_loss_tangent=0.001
  air: permittivity=1.0006 permeability=1.0000004
  epoxy_Kevlar_xy: permittivity=3.6

design HFSSDesign1 (HFSS, HFSS Modal Network, model units mm)
variables:
  Gplane_X = 40mm
  Gplane_Y = Horizontal_YSize+Vertical_Element_Y_Size
  Gplane_Z = 10mm
  Vertical_Element_X_Size = 5mm
  Vertical_Element_Y_Size = 5mm
  Vertical_Element_Z_Size = 13.69526mm
  Horizontal_XSize = 5mm
  Horizontal_ZSize = 5mm
  Horizontal_YSize = 6.5499738cm
  Frequency = 915MHz
  Wavelength = c0/Frequency meter
  Probe_Y = 22.1221558mm
  Probe_Dia = 0.48mm
  Probe_Dielectric_Dia = 1.52mm
  Shield_Dia = 1.98mm
  AirBox_X = Wavelength*0.75
  AirBox_Y = Wavelength*1
  AirBox_Z = Wavelength*1
geometry:
  Ground_Plate [aluminum] = box(corner=(0mm, 0mm, 0mm), size=(Gplane_X, Gplane_Y, Gplane_Z))
  coordinate_system RelativeCS1 = origin=(Gplane_X/2, 0mm, Gplane_Z) x=(1mm, 0mm, 0mm) y=(0mm, 1mm, 0mm)
  Antenna_Vertical_Element [aluminum] = box(corner=(-Vertical_Element_X_Size/2, 0mm, 0mm), size=(Vertical_Element_X_Size, Vertical_Element_Y_Size, Vertical_Element_Z_Size)) in RelativeCS1
  Antenna_Horizontal_Element [aluminum] = box(corner=(-Horizontal_XSize/2, Vertical_Element_Y_Size, Vertical_Element_Z_Size), size=(Horizontal_XSize, Horizontal_YSize, Horizontal_ZSize)) in RelativeCS1
  Box2 [aluminum] = box(corner=(-2.5mm, 0mm, Vertical_Element_Z_Size), size=(5mm, 5mm, 5mm)) in RelativeCS1
  Probe_Feed [copper] = cylinder(axis=Z, base_centre=(Gplane_X/2, Probe_Y, 0), radius=Probe_Dia/2, height=Vertical_Element_Z_Size+Gplane_Z)
  Probe_Dielectric [polyethylene] = cylinder(axis=Z, base_centre=(Gplane_X/2, Probe_Y, 0), radius=Probe_Dielectric_Dia/2, height=Gplane_Z)
  Probe_Feed_1 = Probe_Feed.copy()
  Probe_Dielectric.subtract(Probe_Feed_1)
  Probe_Shield [copper] = cylinder(axis=Z, base_centre=(Gplane_X/2, Probe_Y, 0mm), radius=Shield_Dia/2, height=Gplane_Z)
  Probe_Dielectric_1 = Probe_Dielectric.copy()
  Probe_Shield.subtract(Probe_Dielectric_1)
  Probe_Feed_3 = Probe_Feed.copy()
  Probe_Shield.subtract(Probe_Feed_3)
  Probe_Feed_4 = Probe_Feed.copy()
  Ground_Plate.subtract(Probe_Feed_4)
  AirBox [air] = box(corner=(-AirBox_X/2, -Wavelength*0.375, -Gplane_Z), size=(AirBox_X, AirBox_Y, AirBox_Z+-Gplane_Z/2)) in RelativeCS1
  Probe_Feed_5 = Probe_Feed.copy()
  AirBox.subtract(Probe_Feed_5)
  Probe_Dielectric_2 = Probe_Dielectric.copy()
  Ground_Plate.subtract(Probe_Dielectric_2)
  Probe_Shield_1 = Probe_Shield.copy()
  Ground_Plate.subtract(Probe_Shield_1)
  Box3 [epoxy_Kevlar_xy] = box(corner=(-Vertical_Element_X_Size/2, Vertical_Element_Y_Size, 0mm), size=(Vertical_Element_X_Size, Horizontal_YSize, Vertical_Element_Z_Size)) in RelativeCS1
  Probe_Dielectric_4 = Probe_Dielectric.copy()
  Probe_Feed_6 = Probe_Feed.copy()
  Probe_Shield_4 = Probe_Shield.copy()
  Box3.subtract(Probe_Dielectric_4, Probe_Feed_6, Probe_Shield_4)
  Ground_Plate_1 = Ground_Plate.copy()
  Probe_Dielectric_5 = Probe_Dielectric.copy()
  Probe_Shield_5 = Probe_Shield.copy()
  AirBox.subtract(Ground_Plate_1, Probe_Dielectric_5, Probe_Shield_5)
boundaries and excitations:
  Rad1: Radiation Faces=AirBox.face(at (20, 40.9553, 322.642), at (20, -122.866, 161.321), at (-102.866, 40.9553, 161.321), at (20, 204.776, 161.321), at (142.866, 40.9553, 161.321))
  PerfE1: Perfect E Faces=Ground_Plate.face(-z) InfGroundPlane
  1: Wave Port Faces=Probe_Dielectric.face(-z end) Probe_Shield.face(at (20, 22.1222, 0)) Probe_Feed.face(-z end) WavePortType=Default NumModes=1 Modes{Mode1{IntLine{(20, 22.1221558, 0) -> (20.99, 22.1221558, 0)} CharImp=Zpi}}
  reference conductors: Probe_Shield
setups:
  Setup1: HfssDriven Frequency=915MHz MaxDeltaS=0.02 MaximumPasses=60 MinimumPasses=1 MinimumConvergedPasses=1 PercentRefinement=30 BasisOrder=1 PortAccuracy=2 DrivenSolverType="Direct Solver" VariablesForDerivatives(Horizontal_YSize, Probe_Y, Vertical_Element_Z_Size) VariableFlagsForDerivatives(1, 1, 1) InfiniteSphereSetup=1
    sweep Sweep: 457.5MHz to 1372.5MHz, 401 points; Type=Interpolating SaveFields InterpTolerance=0.5 InterpMaxSolns=250 InterpUsePortImped=false InterpUsePropConst=false PassivityErrorTolerance=0.0001
source amplitudes:
  1:1: 1W 0deg
radiation setups:
  Infinite Sphere1: Infinite Sphere Theta=0deg..180deg step 0.5deg Phi=-180deg..180deg step 0.5deg
reports:
  S Parameter Plot1: dB(S(1,1)) vs Freq on Setup1 : Sweep [Vertical_Element_Z_Size=all Probe_Y=all]; markers MX1 at x=9.15e+08
  S Parameter Chart1: S(1,1) on Setup1 : Sweep [Freq=all Vertical_Element_Z_Size=all Horizontal_YSize=all Probe_Y=all]; markers m1 at 0.915GHz, m2 at 0.915GHz
  Tune S Parameter Plot1: dB(TuneS(1,1,All)) vs Freq on Setup1 : Sweep; markers m1 at 0.9172875GHz, MX1 at x=9.338015e+08
  Realized Gain Plot1: dB(RealizedGainTotal) vs Phi, Theta on Setup1 : LastAdaptive, Infinite Sphere1 [Freq=0.915GHz]
